loadi(strcat(cdsgit_path "/scripts/libMgr/CGlmgrState.il"))
loadi(strcat(cdsgit_path "/scripts/libMgr/CGlmgrCB.il"))
loadi(strcat(cdsgit_path "/scripts/libMgr/CGgitLibs.il"))

loadi(strcat(cdsgit_path "/scripts/commands/CGmergeAbortCB.ils"))
loadi(strcat(cdsgit_path "/scripts/commands/CGremoteCB.ils"))
loadi(strcat(cdsgit_path "/scripts/commands/CGsetWindowsReadOnly.ils"))

loadi(strcat(cdsgit_path "/scripts/forms/CGgetRFchoices.ils"))
loadi(strcat(cdsgit_path "/scripts/forms/CGappendRFchoices.ils"))
